
addrmap I2C_Reg      {
default regwidth = 32;
alignment=8;
	reg {
		name="Command Registers"; desc="I2C Command Registers";
		field {sw=rw; hw=r; desc="Start";} start[0:0]=0x0;
		field { sw=rw; hw=r; desc="TODO";} read[1:1]=0x0;
		field { sw=rw; hw=r; desc="TODO";} write[2:2]=0x0;
		field { sw=rw; hw=r; desc="TODO";} write_multiple[3:3]=0x0;
		field { sw=rw; hw=r; desc="TODO";} stop[4:4]=0x0;
		field {sw=rw; hw=r; desc="Address";} addr[14:8]=0x0;
	} Commands;
	reg {
		field {sw=r; hw=w; desc="Transaction ongoing";} busy[0:0]=0x0;
		field {sw=r; hw=w; desc="Transaction ongoing";} bus_control[1:1]=0x0;
		field {sw=r; hw=w; desc="Transaction ongoing";} bus_active[2:2]=0x0;
		field {sw=r; hw=w; desc="Transaction ongoing";} missed_ack[3:3]=0x0;
	} Status ;
	reg {
		field {sw=rw; hw=r; desc="Prescale";} prescale[15:0]=0x0;
		field {sw=rw; hw=r; desc="Stop on Idle";} stop_on_idle[16:16]=0x0;
	} Cfg;
	reg {
		field {sw=rw; hw=r; desc="TxData";} wdata[7:0]=0x0;
		field {sw=rw; hw=rw; desc="Write Last";} wlast[8:8]=0x0;
	} Wdata ;
	reg {
		field {sw=rw; hw=w; desc="RxData";} rdata[7:0]=0x0;
		field {sw=rw; hw=w; desc="Read Last";} rlast[8:8]=0x0;
	} Rdata ;
};
